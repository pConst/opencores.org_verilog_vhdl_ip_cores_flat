| t27z.ibs * IBIS 4.0 Model
| 512Meg DDR SDRAM - Die Revision "D"
| Valid for DDR1-266 and DDR1-333 operation
| Part Number   VDD/VDDQ   Architecture   Package
| MT46V128M4TG   2.5V/2.5V   128 Meg x 4   66-pin TSOP
| MT46V64M8TG   2.5V/2.5V   64 Meg x 8   66-pin TSOP
| MT46V128M4FN   2.5V/2.5V   128 Meg x 4   60-ball FBGA
| MT46V64M8FN   2.5V/2.5V   64 Meg x 8   60-ball FBGA
[IBIS Ver]   4.0
[File name]   t27z.ibs
[File Rev]   2.1
[Date]   07/05/2005
[Source]   From silicon level SPICE model at Micron Technology, Inc.
   Micron Technology, Inc.
   8000 S. Federal Way
   P.O. Box 6, M/S: 01-711
   Boise, ID 83707-0006
[Notes]   Rev 2.0: 06/02/2005
   - Model, matched to latest silicon measurements
   Rev 2.1: 07/05/2005
   - INPUT and CLK_INPUT model clamp curves updated
[Disclaimer]  This software code and all associated documentation, comments
              or other information (collectively "Software") is provided
              "AS IS" without warranty of any kind. MICRON TECHNOLOGY, INC.
              ("MTI") EXPRESSLY DISCLAIMS ALL WARRANTIES EXPRESS OR IMPLIED,
              INCLUDING BUT NOT LIMITED TO, NONINFRINGEMENT OF THIRD PARTY
              RIGHTS, AND ANY IMPLIED WARRANTIES OF MERCHANTABILITY OR
              FITNESS FOR ANY PARTICULAR PURPOSE. MTI DOES NOT WARRANT THAT
              THE SOFTWARE WILL MEET YOUR REQUIREMENTS, OR THAT THE
              OPERATION OF THE SOFTWARE WILL BE UNINTERRUPTED OR ERROR-FREE.
              FURTHERMORE, MTI DOES NOT MAKE ANY REPRESENTATIONS REGARDING
              THE USE OR THE RESULTS OF THE USE OF THE SOFTWARE IN TERMS OF
              ITS CORRECTNESS, ACCURACY, RELIABILITY, OR OTHERWISE. THE
              ENTIRE RISK ARISING OUT OF USE OR PERFORMANCE OF THE SOFTWARE
              REMAINS WITH YOU. IN NO EVENT SHALL MTI, ITS AFFILIATED
              COMPANIES OR THEIR SUPPLIERS BE LIABLE FOR ANY DIRECT,
              INDIRECT, CONSEQUENTIAL, INCIDENTAL, OR SPECIAL DAMAGES
              (INCLUDING, WITHOUT LIMITATION, DAMAGES FOR LOSS OF PROFITS,
              BUSINESS INTERRUPTION, OR LOSS OF INFORMATION) ARISING OUT OF
              YOUR USE OF OR INABILITY TO USE THE SOFTWARE, EVEN IF MTI HAS
              BEEN ADVISED OF THE POSSIBILITY OF SUCH DAMAGES. Because some
              jurisdictions prohibit the exclusion or limitation of
              liability for consequential or incidental damages, the above
              limitation may not apply to you.
[Copyright]   Copyright 2005 Micron Technology, Inc. All Rights Reserved.
|   COMPONENT: MT46V128M4TG
[Component]   MT46V128M4TG
[Manufacturer]  Micron Technology, Inc.
[Package]  | TSOP package
|   typ   min   max
R_pkg   41.78m   32.10m   51.46m
L_pkg   4.20nH   2.32nH   6.09nH
C_pkg   1.21pF   0.93pF   1.48pF
[Pin]   signal_name   model_name   R_pin   L_pin   C_pin
1   VDD   POWER   27.40m   3.90nH   3.55pF
2   NC   NC
3   VDDQ   POWER   44.58m   5.73nH   1.36pF
4   NC   NC
5   DQ0   DQ_BUFF   42.54m   4.96nH   1.34pF
6   VSSQ   GND   42.21m   4.58nH   1.32pF
7   NC   NC
8   NC   NC
9   VDDQ   POWER   39.89m   3.43nH   1.28pF
10   NC   NC
11   DQ1   DQ_BUFF   37.41m   2.78nH   1.25pF
12   VSSQ   GND   36.80m   2.68nH   1.17pF
13   NC   NC
14   NC   NC
15   NC   NC
16   NC   NC
17   NC   NC
18   VDD   POWER   30.93m   2.36nH   1.35pF
19   NC   NC
20   NC   NC
21   WE#   INPUT   39.36m   2.80nH   1.21pF
22   CAS#   INPUT   42.19m   2.93nH   1.28pF
23   RAS#   INPUT   43.66m   3.07nH   1.37pF
24   CS#   INPUT   44.70m   3.40nH   1.30pF
25   NC   NC
26   BA0   INPUT   48.79m   4.07nH   1.39pF
27   BA1   INPUT   49.55m   4.35nH   1.42pF
28   A10/AP   INPUT   50.64m   4.68nH   1.44pF
29   A0   INPUT   50.94m   5.00nH   1.46pF
30   A1   INPUT   51.46m   5.38nH   1.48pF
31   A2   INPUT   50.65m   5.76nH   1.45pF
32   A3   INPUT   46.15m   6.09nH   1.44pF
33   VDD   POWER   27.40m   3.90nH   3.55pF
34   VSS   GND   27.36m   3.89nH   4.17pF
35   A4   INPUT   46.21m   6.07nH   1.41pF
36   A5   INPUT   50.39m   5.72nH   1.44pF
37   A6   INPUT   51.24m   5.33nH   1.47pF
38   A7   INPUT   50.91m   4.96nH   1.46pF
39   A8   INPUT   50.51m   4.62nH   1.44pF
40   A9   INPUT   49.60m   4.29nH   1.42pF
41   A11   INPUT   49.43m   3.99nH   1.41pF
42   A12   INPUT   47.16m   3.65nH   1.41pF
43   NC   NC
44   CKE   INPUT   42.56m   2.97nH   1.35pF
45   CK   CLK_INPUT   40.83m   2.84nH   1.28pF
46   CK#   CLK_INPUT   39.38m   2.71nH   1.22pF
47   DM   DM_INPUT   38.22m   2.61nH   1.17pF
48   VSS   GND   37.16m   2.52nH   1.12pF
49   VREF   POWER   35.47m   2.44nH   1.05pF
50   NC   NC
51   DQS   DQ_BUFF   32.10m   2.32nH   0.93pF
52   NC   NC
53   NC   NC
54   NC   NC
55   VDDQ   POWER   36.87m   2.66nH   1.18pF
56   DQ2   DQ_BUFF   37.25m   2.76nH   1.25pF
57   NC   NC
58   VSSQ   GND   39.62m   3.39nH   1.26pF
59   NC   NC
60   NC   NC
61   VDDQ   POWER   42.27m   4.51nH   1.30pF
62   DQ3   DQ_BUFF   42.28m   4.91nH   1.31pF
63   NC   NC
64   VSSQ   GND   44.38m   5.68nH   1.34pF
65   NC   NC
66   VSS   GND   27.36m   3.89nH   4.17pF
|**********************DIFF PIN*********************************************
[Diff_pin]   inv_pin   vdiff   tdelay_typ   tdelay_min   tdelay_max
   45   46   .360V   0ns   NA   NA
|   COMPONENT: MT46V64M8TG
[Component]   MT46V64M8TG
[Manufacturer]  Micron Technology, Inc.
[Package]  | TSOP package
|   typ   min   max
R_pkg   41.78m   32.10m   51.46m
L_pkg   4.20nH   2.32nH   6.09nH
C_pkg   1.21pF   0.93pF   1.48pF
[Pin]   signal_name   model_name   R_pin   L_pin   C_pin
1   VDD   POWER   27.40m   3.90nH   3.55pF
2   DQ0   DQ_BUFF   41.66m   6.04nH   1.37pF
3   VDDQ   POWER   44.58m   5.73nH   1.36pF
4   NC   NC
5   DQ1   DQ_BUFF   42.54m   4.96nH   1.34pF
6   VSSQ   GND   42.21m   4.58nH   1.32pF
7   NC   NC
8   DQ2   DQ_BUFF   39.67m   3.81nH   1.29pF
9   VDDQ   POWER   39.89m   3.43nH   1.28pF
10   NC   NC
11   DQ3   DQ_BUFF   37.41m   2.78nH   1.25pF
12   VSSQ   GND   36.80m   2.68nH   1.17pF
13   NC   NC
14   NC   NC
15   NC   NC
16   NC   NC
17   NC   NC
18   VDD   POWER   30.93m   2.36nH   1.35pF
19   NC   NC
20   NC   NC
21   WE#   INPUT   39.36m   2.80nH   1.21pF
22   CAS#   INPUT   42.19m   2.93nH   1.28pF
23   RAS#   INPUT   43.66m   3.07nH   1.37pF
24   CS#   INPUT   44.70m   3.40nH   1.30pF
25   NC   NC
26   BA0   INPUT   48.79m   4.07nH   1.39pF
27   BA1   INPUT   49.55m   4.35nH   1.42pF
28   A10/AP   INPUT   50.64m   4.68nH   1.44pF
29   A0   INPUT   50.94m   5.00nH   1.46pF
30   A1   INPUT   51.46m   5.38nH   1.48pF
31   A2   INPUT   50.65m   5.76nH   1.45pF
32   A3   INPUT   46.15m   6.09nH   1.44pF
33   VDD   POWER   27.40m   3.90nH   3.55pF
34   VSS   GND   27.36m   3.89nH   4.17pF
35   A4   INPUT   46.21m   6.07nH   1.41pF
36   A5   INPUT   50.39m   5.72nH   1.44pF
37   A6   INPUT   51.24m   5.33nH   1.47pF
38   A7   INPUT   50.91m   4.96nH   1.46pF
39   A8   INPUT   50.51m   4.62nH   1.44pF
40   A9   INPUT   49.60m   4.29nH   1.42pF
41   A11   INPUT   49.43m   3.99nH   1.41pF
42   A12   INPUT   47.16m   3.65nH   1.41pF
43   NC   NC
44   CKE   INPUT   42.56m   2.97nH   1.35pF
45   CK   CLK_INPUT   40.83m   2.84nH   1.28pF
46   CK#   CLK_INPUT   39.38m   2.71nH   1.22pF
47   DM   DM_INPUT   38.22m   2.61nH   1.17pF
48   VSS   GND   37.16m   2.52nH   1.12pF
49   VREF   POWER   35.47m   2.44nH   1.05pF
50   NC   NC
51   DQS   DQ_BUFF   32.10m   2.32nH   0.93pF
52   NC   NC
53   NC   NC
54   NC   NC
55   VDDQ   POWER   36.87m   2.66nH   1.18pF
56   DQ4   DQ_BUFF   37.25m   2.76nH   1.25pF
57   NC   NC
58   VSSQ   GND   39.62m   3.39nH   1.26pF
59   DQ5   DQ_BUFF   39.75m   3.76nH   1.26pF
60   NC   NC
61   VDDQ   POWER   42.27m   4.51nH   1.30pF
62   DQ6   DQ_BUFF   42.28m   4.91nH   1.31pF
63   NC   NC
64   VSSQ   GND   44.38m   5.68nH   1.34pF
65   DQ7   DQ_BUFF   41.63m   6.01nH   1.36pF
66   VSS   GND   27.36m   3.89nH   4.17pF
|**********************DIFF PIN*********************************************
[Diff_pin]   inv_pin   vdiff   tdelay_typ   tdelay_min   tdelay_max
   45   46   .360V   0ns   NA   NA
|   COMPONENT: MT46V128M4FN   10mm x 12.5mm FBGA
[Component]   MT46V128M4FN
[Manufacturer]  Micron Technology, Inc.
[Package]  | FBGA package
|   typ   min   max
R_pkg   142m   129m   156m
L_pkg   1.96nH   1.47nH   2.45nH
C_pkg   0.34pF   0.27pF   0.41pF
[Pin]   signal_name   model_name   R_pin   L_pin   C_pin
A1   VSSQ   GND
A2   NF   NC
A3   VSS   GND   143m   2.01nH   0.35pF
A7   VDD   POWER   142m   1.99nH   0.38pF
A8   NF   NC
A9   VDDQ   POWER
B1   NC   NC
B2   VDDQ   POWER   9.35m   0.245nH   NA
B3   DQ3   DQ_BUFF   143m   1.95nH   0.39pF
B7   DQ0   DQ_BUFF   144m   2.03nH   0.38pF
B8   VSSQ   GND   170m   3.02nH   0.40pF
B9   NC   NC
C1   NC   NC
C2   VSSQ   GND   155m   2.48nH   0.35pF
C3   NF   NC
C7   NF   NC
C8   VDDQ   POWER   153m   2.40nH   0.79pF
C9   NC   NC
D1   NC   NC
D2   VDDQ   POWER   150m   2.30nH   0.34pF
D3   DQ2   DQ_BUFF   133m   1.58nH   0.31pF
D7   DQ1   DQ_BUFF   135m   1.64nH   0.32pF
D8   VSSQ   GND   148m   2.23nH   0.38pF
D9   NC   NC
E1   NC   NC
E2   VSSQ   GND   145m   2.18nH   0.29pF
E3   DQS   DQ_BUFF   133m   1.56nH   0.29pF
E7   NC   NC
E8   VDDQ   POWER   143m   2.03nH   0.66pF
E9   NC   NC
F1   VREF   POWER   156m   2.51nH   0.31pF
F2   VSS   GND   75.9m   1.09nH   0.21pF
F3   DM   DM_INPUT   141m   1.85nH   0.35pF
F7   NC   NC
F8   VDD   POWER   3.05m   1.05nH   NA
F9   NC   NC
G2   CK   CLK_INPUT   144m   2.05nH   0.30pF
G3   CK#   CLK_INPUT   132m   1.54nH   0.31pF
G7   WE#   INPUT   129m   1.47nH   0.27pF
G8   CAS#   INPUT   142m   2.02nH   0.27pF
H2   A12   INPUT   144m   2.02nH   0.29pF
H3   CKE   INPUT   130m   1.47nH   0.29pF
H7   RAS#   INPUT   130m   1.50nH   0.29pF
H8   CS#   INPUT   145m   2.06nH   0.29pF
J2   A11   INPUT   143m   2.01nH   0.29pF
J3   A9   INPUT   131m   1.49nH   0.29pF
J7   BA1   INPUT   131m   1.53nH   0.29pF
J8   BA0   INPUT   144m   2.03nH   0.29pF
K2   A8   INPUT   143m   2.09nH   0.29pF
K3   A7   INPUT   132m   1.57nH   0.29pF
K7   A0   INPUT   134m   1.68nH   0.31pF
K8   A10/AP   INPUT   145m   2.13nH   0.29pF
L2   A6   INPUT   147m   2.22nH   0.32pF
L3   A5   INPUT   136m   1.72nH   0.34pF
L7   A2   INPUT   139m   1.81nH   0.33pF
L8   A1   INPUT   149m   2.31nH   0.31pF
M2   A4   INPUT   151m   2.38nH   0.35pF
M3   VSS   GND   141m   2.00nH   0.34pF
M7   VDD   POWER   143m   2.03nH   0.66pF
M8   A3   INPUT   153m   2.45nH   0.35pF
|**********************DIFF PIN*********************************************
[Diff_pin]   inv_pin   vdiff   tdelay_typ   tdelay_min   tdelay_max
   G2   G3   .360V   0ns   NA   NA
|   COMPONENT: MT46V64M8FN   10mm x 12.5mm FBGA
[Component]   MT46V64M8FN
[Manufacturer]  Micron Technology, Inc.
[Package]  | FBGA package
|   typ   min   max
R_pkg   142m   129m   156m
L_pkg   1.96nH   1.47nH   2.45nH
C_pkg   0.34pF   0.27pF   0.41pF
[Pin]   signal_name   model_name   R_pin   L_pin   C_pin
A1   VSSQ   GND
A2   DQ7   DQ_BUFF   156m   2.44nH   0.389pF
A3   VSS   GND   143m   2.01nH   0.352pF
A7   VDD   POWER   142m   1.99nH   0.375pF
A8   DQ0   DQ_BUFF   156m   2.35nH   0.414pF
A9   VDDQ   POWER
B1   NC   NC
B2   VDDQ   POWER   9.35m   0.245nH   NA
B3   DQ6   DQ_BUFF   143m   1.95nH   0.385pF
B7   DQ1   DQ_BUFF   144m   2.03nH   0.379pF
B8   VSSQ   GND   170m   3.02nH   0.401pF
B9   NC   NC
C1   NC   NC
C2   VSSQ   GND   155m   2.48nH   0.348pF
C3   DQ5   DQ_BUFF   137m   1.73nH   0.328pF
C7   DQ2   DQ_BUFF   139m   1.80nH   0.345pF
C8   VDDQ   POWER   153m   2.40nH   0.788pF
C9   NC   NC
D1   NC   NC
D2   VDDQ   POWER   150m   2.30nH   0.34pF
D3   DQ4   DQ_BUFF   133m   1.58nH   0.31pF
D7   DQ3   DQ_BUFF   135m   1.64nH   0.32pF
D8   VSSQ   GND   148m   2.23nH   0.33pF
D9   NC   NC
E1   NC   NC
E2   VSSQ   GND   145m   2.18nH   0.29pF
E3   DQS   DQ_BUFF   133m   1.56nH   0.29pF
E7   NC   NC
E8   VDDQ   POWER   143m   2.03nH   0.67pF
E9   NC   NC
F1   VREF   POWER   156m   2.51nH   0.31pF
F2   VSS   GND   75.9m   1.09nH   0.21pF
F3   DM   DM_INPUT   141m   1.85nH   0.35pF
F7   NC   NC
F8   VDD   POWER   3.05m   1.05nH   NA
F9   NC   NC
G2   CK   CLK_INPUT   144m   2.05nH   0.30pF
G3   CK#   CLK_INPUT   132m   1.54nH   0.31pF
G7   WE#   INPUT   129m   1.47nH   0.27pF
G8   CAS#   INPUT   142m   2.02nH   0.27pF
H2   A12   INPUT   144m   2.02nH   0.29pF
H3   CKE   INPUT   130m   1.47nH   0.29pF
H7   RAS#   INPUT   130m   1.50nH   0.29pF
H8   CS#   INPUT   145m   2.06nH   0.29pF
J2   A11   INPUT   143m   2.01nH   0.29pF
J3   A9   INPUT   131m   1.49nH   0.29pF
J7   BA1   INPUT   131m   1.53nH   0.29pF
J8   BA0   INPUT   144m   2.03nH   0.29pF
K2   A8   INPUT   143m   2.09nH   0.29pF
K3   A7   INPUT   132m   1.57nH   0.29pF
K7   A0   INPUT   134m   1.68nH   0.31pF
K8   A10/AP   INPUT   145m   2.13nH   0.29pF
L2   A6   INPUT   147m   2.22nH   0.32pF
L3   A5   INPUT   136m   1.72nH   0.34pF
L7   A2   INPUT   139m   1.81nH   0.33pF
L8   A1   INPUT   149m   2.31nH   0.31pF
M2   A4   INPUT   151m   2.38nH   0.35pF
M3   VSS   GND   141m   2.00nH   0.34pF
M7   VDD   POWER   143m   2.03nH   0.66pF
M8   A3   INPUT   153m   2.45nH   0.35pF
|**********************DIFF PIN*********************************************
[Diff_pin]   inv_pin   vdiff   tdelay_typ   tdelay_min   tdelay_max
   G2   G3   .360V   0ns   NA   NA
| Models and submodels in the file (4): DQ_BUFF (I/O), INPUT (Input), CLK_INPUT (Input), DM_INPUT (Input)
