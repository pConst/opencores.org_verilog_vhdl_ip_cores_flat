| t37z.ibs * IBIS 4.0 Model
| 512Meg DDR SDRAM - Die Revision "F"
| Valid for DDR1-266 and DDR1-333 operation
| Part Number   VDD/VDDQ   Architecture   Package
| MT46V128M4TG   2.5V/2.5V   128 Meg x 4   66-pin TSOP
| MT46V64M8TG   2.5V/2.5V   64 Meg x 8   66-pin TSOP
| MT46V32M16TG   2.5V/2.5V   32 Meg x 16   66-pin TSOP
| MT46V128M4FN   2.5V/2.5V   128 Meg x 4   60-ball FBGA
| MT46V64M8FN   2.5V/2.5V   64 Meg x 8   60-ball FBGA
| MT46V32M16FN   2.5V/2.5V   32 Meg x 16   60-ball FBGA
[IBIS Ver]   4.0
[File name]   t37z.ibs
[File Rev]   2.1
[Date]   11/21/2005
[Source]   From silicon level SPICE model at Micron Technology, Inc.
   Micron Technology, Inc.
   8000 S. Federal Way
   P.O. Box 6, M/S: 01-711
   Boise, ID 83707-0006
[Notes]   Rev 2.0: 08/25/2005
   -Model matched to latest silicon measurements
   Rev 2.1: 11/21/2005
   -Updated FBGA package capacitance
   -Updated c_comp for all the models
   -Model updated to latest design revision
   -Added IBIS Quality Notes
   IBIS Quality Notes
|IQ SUMMARY Overall Quality of component and models Level 2b
|IQ Level 0 - 0 errors 0 warnings
|IQ Level 1 - All checks done for completeness and correctness
|IQ Level 2 - HSPICE Correlation
|IQ Buffer DQ_FULL/DQ_HALF/INPUT/CLK_INPUT/DM_INPUT: Quality level 2b
|IQ Level 1
|   All Level 1 checks performed and are either OK or NA
|IQ Level 2
|   Using VT IBIS Data compared to source hspice models
|IQ Level 2b
|   C_comp laboratory and hspice correlation
|IQ BEGIN IBIS Quality Checklist
|IQ FILE: t37z.ibs   IQ Level:   1
|IQ COMPONENT: MT46V128M4TG   IQ Level:   1
|IQ COMPONENT: MT46V64M8TG   IQ Level:   1
|IQ COMPONENT: MT46V32M16TG   IQ Level:   1
|IQ COMPONENT: MT46V128M4FN   IQ Level:   1
|IQ COMPONENT: MT46V64M8FN   IQ Level:   1
|IQ COMPONENT: MT46V32M16FN   IQ Level:   1
|IQ MODEL: DQ_FULL   IQ Level:   2b
|IQ MODEL: DQ_HALF   IQ Level:   2b
|IQ MODEL: DM_INPUT   IQ Level:   2b
|IQ MODEL: INPUT   IQ Level:   2b
|IQ MODEL: CLK_INPUT   IQ Level:   2b
|IQ END IBIS Quality Checklist
[Disclaimer]  This software code and all associated documentation, comments
              or other information (collectively "Software") is provided
              "AS IS" without warranty of any kind. MICRON TECHNOLOGY, INC.
              ("MTI") EXPRESSLY DISCLAIMS ALL WARRANTIES EXPRESS OR IMPLIED,
              INCLUDING BUT NOT LIMITED TO, NONINFRINGEMENT OF THIRD PARTY
              RIGHTS, AND ANY IMPLIED WARRANTIES OF MERCHANTABILITY OR
              FITNESS FOR ANY PARTICULAR PURPOSE. MTI DOES NOT WARRANT THAT
              THE SOFTWARE WILL MEET YOUR REQUIREMENTS, OR THAT THE
              OPERATION OF THE SOFTWARE WILL BE UNINTERRUPTED OR ERROR-FREE.
              FURTHERMORE, MTI DOES NOT MAKE ANY REPRESENTATIONS REGARDING
              THE USE OR THE RESULTS OF THE USE OF THE SOFTWARE IN TERMS OF
              ITS CORRECTNESS, ACCURACY, RELIABILITY, OR OTHERWISE. THE
              ENTIRE RISK ARISING OUT OF USE OR PERFORMANCE OF THE SOFTWARE
              REMAINS WITH YOU. IN NO EVENT SHALL MTI, ITS AFFILIATED
              COMPANIES OR THEIR SUPPLIERS BE LIABLE FOR ANY DIRECT,
              INDIRECT, CONSEQUENTIAL, INCIDENTAL, OR SPECIAL DAMAGES
              (INCLUDING, WITHOUT LIMITATION, DAMAGES FOR LOSS OF PROFITS,
              BUSINESS INTERRUPTION, OR LOSS OF INFORMATION) ARISING OUT OF
              YOUR USE OF OR INABILITY TO USE THE SOFTWARE, EVEN IF MTI HAS
              BEEN ADVISED OF THE POSSIBILITY OF SUCH DAMAGES. Because some
              jurisdictions prohibit the exclusion or limitation of
              liability for consequential or incidental damages, the above
              limitation may not apply to you.
[Copyright]   Copyright 2005 Micron Technology, Inc. All Rights Reserved.
|   COMPONENT: MT46V128M4TG
[Component]   MT46V128M4TG
[Manufacturer]  Micron Technology, Inc.
[Package]  | TSOP package
|   typ   min   max
R_pkg   46.96m   34.54m   59.38m
L_pkg   4.82nH   2.76nH   6.88nH
C_pkg   1.23pF   0.91pF   1.54pF
[Pin]   signal_name   model_name   R_pin   L_pin   C_pin
1   VDD   POWER   9.90m   1.38nH   1.18pF
2   NF   NC
3   VDDQ   POWER   58.14m   6.42nH   1.56pF
4   NC   NC
5   DQ0   DQ_FULL   58.17m   5.63nH   1.49pF
6   VSSQ   GND   56.76m   5.25nH   1.46pF
7   NC   NC
8   NF   NC
9   VDDQ   POWER   50.81m   4.10nH   1.36pF
10   NC   NC
11   DQ1   DQ_FULL   45.07m   3.61nH   1.25pF
12   VSSQ   GND   43.84m   3.45nH   1.21pF
13   NC   NC
14   NC   NC
15   VDDQ   POWER   36.13m   2.88nH   0.98pF
16   NC   NC
17   NC   NC
18   VDD   POWER   33.97m   2.76nH   0.90pF
19   NC   NC
20   NC   NC
21   WE#   INPUT   39.03m   3.10nH   1.11pF
22   CAS#   INPUT   40.55m   3.30nH   1.14pF
23   RAS#   INPUT   40.87m   3.45nH   1.20pF
24   CS#   INPUT   43.66m   3.64nH   1.25pF
25   NC   NC
26   BA0   INPUT   48.36m   4.31nH   1.35pF
27   BA1   INPUT   50.42m   4.68nH   1.39pF
28   A10/AP   INPUT   51.99m   5.05nH   1.42pF
29   A0   INPUT   53.77m   5.47nH   1.45pF
30   A1   INPUT   54.49m   5.85nH   1.51pF
31   A2   INPUT   55.17m   6.26nH   1.54pF
32   A3   INPUT   54.56m   6.74nH   1.51pF
33   VDD   POWER   9.90m   1.38nH   1.18pF
34   VSS   GND   9.94m   1.38nH   1.39pF
35   A4   INPUT   54.78m   6.78nH   1.50pF
36   A5   INPUT   55.41m   6.29nH   1.54pF
37   A6   INPUT   54.77m   5.84nH   1.49pF
38   A7   INPUT   53.77m   5.42nH   1.46pF
39   A8   INPUT   52.65m   5.03nH   1.42pF
40   A9   INPUT   51.12m   4.66nH   1.39pF
41   A11   INPUT   49.58m   4.29nH   1.34pF
42   A12   INPUT   48.36m   3.98nH   1.27pF
43   NC   NC
44   CKE   INPUT   48.36m   3.98nH   1.27pF
45   CK   CLK_INPUT   41.91m   3.25nH   1.10pF
46   CK#   CLK_INPUT   40.29m   3.07nH   1.07pF
47   DM   DM_INPUT   38.69m   2.92nH   1.03pF
48   VSS   GND   34.29m   2.73nH   1.02pF
49   VREF   POWER   33.31m   2.68nH   0.94pF
50   NC   NC
51   DQS   DQ_FULL   36.79m   2.76nH   0.91pF
52   VSSQ   GND   37.68m   2.83nH   0.94pF
53   NC   NC
54   NC   NC
55   VDDQ   POWER   44.63m   3.40nH   1.17pF
56   DQ2   DQ_FULL   45.67m   3.56nH   1.21pF
57   NC   NC
58   VSSQ   GND   50.93m   4.09nH   1.33pF
59   NF   NC
60   NC   NC
61   VDDQ   POWER   56.54m   5.25nH   1.44pF
62   DQ3   DQ_FULL   57.90m   5.63nH   1.48pF
63   NC   NC
64   VSSQ   GND   58.19m   6.43nH   1.55pF
65   NF   NC
66   VSS   GND   9.94m   1.38nH   1.39pF
|**********************DIFF PIN*********************************************
[Diff_pin]   inv_pin   vdiff   tdelay_typ   tdelay_min   tdelay_max
   45   46   .360V   0ns   NA   NA
|   COMPONENT: MT46V64M8TG
[Component]   MT46V64M8TG
[Manufacturer]  Micron Technology, Inc.
[Package]  | TSOP package
|   typ   min   max
R_pkg   46.96m   34.54m   59.38m
L_pkg   4.82nH   2.76nH   6.88nH
C_pkg   1.23pF   0.91pF   1.54pF
[Pin]   signal_name   model_name   R_pin   L_pin   C_pin
1   VDD   POWER   9.90m   1.38nH   1.18pF
2   DQ0   DQ_FULL   57.22m   6.87nH   1.49pF
3   VDDQ   POWER   58.14m   6.42nH   1.56pF
4   NC   NC
5   DQ1   DQ_FULL   58.17m   5.63nH   1.49pF
6   VSSQ   GND   56.76m   5.25nH   1.46pF
7   NC   NC
8   DQ2   DQ_FULL   53.35m   4.48nH   1.40pF
9   VDDQ   POWER   50.81m   4.10nH   1.36pF
10   NC   NC
11   DQ3   DQ_FULL   45.07m   3.61nH   1.25pF
12   VSSQ   GND   43.84m   3.45nH   1.21pF
13   NC   NC
14   NC   NC
15   VDDQ   POWER   36.13m   2.88nH   0.98pF
16   NC   NC
17   NC   NC
18   VDD   POWER   33.97m   2.76nH   0.90pF
19   NC   NC
20   NC   NC
21   WE#   INPUT   39.03m   3.10nH   1.11pF
22   CAS#   INPUT   40.55m   3.30nH   1.14pF
23   RAS#   INPUT   40.87m   3.45nH   1.20pF
24   CS#   INPUT   43.66m   3.64nH   1.25pF
25   NC   NC
26   BA0   INPUT   48.36m   4.31nH   1.35pF
27   BA1   INPUT   50.42m   4.68nH   1.39pF
28   A10/AP   INPUT   51.99m   5.05nH   1.42pF
29   A0   INPUT   53.77m   5.47nH   1.45pF
30   A1   INPUT   54.49m   5.85nH   1.51pF
31   A2   INPUT   55.17m   6.26nH   1.54pF
32   A3   INPUT   54.56m   6.74nH   1.51pF
33   VDD   POWER   9.90m   1.38nH   1.18pF
34   VSS   GND   9.94m   1.38nH   1.39pF
35   A4   INPUT   54.78m   6.78nH   1.50pF
36   A5   INPUT   55.41m   6.29nH   1.54pF
37   A6   INPUT   54.77m   5.84nH   1.49pF
38   A7   INPUT   53.77m   5.42nH   1.46pF
39   A8   INPUT   52.65m   5.03nH   1.42pF
40   A9   INPUT   51.12m   4.66nH   1.39pF
41   A11   INPUT   49.58m   4.29nH   1.34pF
42   A12   INPUT   48.36m   3.98nH   1.27pF
43   NC   NC
44   CKE   INPUT   48.36m   3.98nH   1.27pF
45   CK   CLK_INPUT   41.91m   3.25nH   1.10pF
46   CK#   CLK_INPUT   40.29m   3.07nH   1.07pF
47   DM   DM_INPUT   38.69m   2.92nH   1.03pF
48   VSS   GND   34.29m   2.73nH   1.02pF
49   VREF   POWER   33.31m   2.68nH   0.94pF
50   NC   NC
51   DQS   DQ_FULL   36.79m   2.76nH   0.91pF
52   VSSQ   GND   37.68m   2.83nH   0.94pF
53   NC   NC
54   NC   NC
55   VDDQ   POWER   44.63m   3.40nH   1.17pF
56   DQ4   DQ_FULL   45.67m   3.56nH   1.21pF
57   NC   NC
58   VSSQ   GND   50.93m   4.09nH   1.33pF
59   DQ5   DQ_FULL   53.24m   4.48nH   1.36pF
60   NC   NC
61   VDDQ   POWER   56.54m   5.25nH   1.44pF
62   DQ6   DQ_FULL   57.90m   5.63nH   1.48pF
63   NC   NC
64   VSSQ   GND   58.19m   6.43nH   1.55pF
65   DQ7   DQ_FULL   57.50m   6.88nH   1.49pF
66   VSS   GND   9.94m   1.38nH   1.39pF
|**********************DIFF PIN*********************************************
[Diff_pin]   inv_pin   vdiff   tdelay_typ   tdelay_min   tdelay_max
   45   46   .360V   0ns   NA   NA
|   COMPONENT: MT46V32M16TG
[Component]   MT46V32M16TG
[Manufacturer]  Micron Technology, Inc.
[Package]  | TSOP package
|   typ   min   max
R_pkg   46.96m   34.54m   59.38m
L_pkg   4.82nH   2.76nH   6.88nH
C_pkg   1.23pF   0.91pF   1.54pF
[Pin]   signal_name   model_name   R_pin   L_pin   C_pin
1   VDD   POWER   9.90m   1.38nH   1.18pF
2   DQ0   DQ   57.22m   6.87nH   1.49pF
3   VDDQ   POWER   58.14m   6.42nH   1.56pF
4   DQ1   DQ   59.38m   6.03nH   1.52pF
5   DQ2   DQ   58.17m   5.63nH   1.49pF
6   VSSQ   GND   56.76m   5.25nH   1.46pF
7   DQ3   DQ   55.01m   4.86nH   1.44pF
8   DQ4   DQ   53.35m   4.48nH   1.40pF
9   VDDQ   POWER   50.81m   4.10nH   1.36pF
10   DQ5   DQ   46.92m   3.73nH   1.32pF
11   DQ6   DQ   45.07m   3.61nH   1.25pF
12   VSSQ   GND   43.84m   3.45nH   1.21pF
13   DQ7   DQ   40.94m   3.26nH   1.14pF
14   NC   NC
15   VDDQ   POWER   36.13m   2.88nH   0.98pF
16   LDQS   DQ   34.54m   2.78nH   0.93pF
17   NC   NC
18   VDD   POWER   33.97m   2.76nH   0.90pF
19   NC   NC
20   LDM   DM_INPUT   36.78m   2.96nH   1.04pF
21   WE#   INPUT   39.03m   3.10nH   1.11pF
22   CAS#   INPUT   40.55m   3.30nH   1.14pF
23   RAS#   INPUT   40.87m   3.45nH   1.20pF
24   CS#   INPUT   43.66m   3.64nH   1.25pF
25   NC   NC
26   BA0   INPUT   48.36m   4.31nH   1.35pF
27   BA1   INPUT   50.42m   4.68nH   1.39pF
28   A10/AP   INPUT   51.99m   5.05nH   1.42pF
29   A0   INPUT   53.77m   5.47nH   1.45pF
30   A1   INPUT   54.49m   5.85nH   1.51pF
31   A2   INPUT   55.17m   6.26nH   1.54pF
32   A3   INPUT   54.56m   6.74nH   1.51pF
33   VDD   POWER   9.90m   1.38nH   1.18pF
34   VSS   GND   9.94m   1.38nH   1.39pF
35   A4   INPUT   54.78m   6.78nH   1.50pF
36   A5   INPUT   55.41m   6.29nH   1.54pF
37   A6   INPUT   54.77m   5.84nH   1.49pF
38   A7   INPUT   53.77m   5.42nH   1.46pF
39   A8   INPUT   52.65m   5.03nH   1.42pF
40   A9   INPUT   51.12m   4.66nH   1.39pF
41   A11   INPUT   49.58m   4.29nH   1.34pF
42   A12   INPUT   48.36m   3.98nH   1.27pF
43   NC   NC
44   CKE   INPUT   48.36m   3.98nH   1.27pF
45   CK   CLK_INPUT   41.91m   3.25nH   1.10pF
46   CK#   CLK_INPUT   40.29m   3.07nH   1.07pF
47   UDM   DM_INPUT   38.69m   2.92nH   1.03pF
48   VSS   GND   34.29m   2.73nH   1.02pF
49   VREF   POWER   33.31m   2.68nH   0.94pF
50   NC   NC
51   UDQS   DQ   36.79m   2.76nH   0.91pF
52   VSSQ   GND   37.68m   2.83nH   0.94pF
53   NC   NC
54   DQ8   DQ   42.13m   3.23nH   1.10pF
55   VDDQ   POWER   44.63m   3.40nH   1.17pF
56   DQ9   DQ   45.67m   3.56nH   1.21pF
57   DQ10   DQ   47.23m   3.70nH   1.28pF
58   VSSQ   GND   50.93m   4.09nH   1.33pF
59   DQ11   DQ   53.24m   4.48nH   1.36pF
60   DQ12   DQ   55.00m   4.87nH   1.40pF
61   VDDQ   POWER   56.54m   5.25nH   1.44pF
62   DQ13   DQ   57.90m   5.63nH   1.48pF
63   DQ14   DQ   59.24m   6.02nH   1.50pF
64   VSSQ   GND   58.19m   6.43nH   1.55pF
65   DQ15   DQ   57.50m   6.88nH   1.49pF
66   VSS   GND   9.94m   1.38nH   1.39pF
|**********************DIFF PIN*********************************************
[Diff_pin]   inv_pin   vdiff   tdelay_typ   tdelay_min   tdelay_max
   45   46   .360V   0ns   NA   NA
|***********************MODEL SELECTOR**************************************
[Model Selector] DQ
DQ_FULL   Full-Strength IO Driver
DQ_HALF   54% Reduced Drive Strength IO Driver
|   COMPONENT: MT46V128M4FN   10mm x 12.5mm FBGA
[Component]   MT46V128M4FN
[Manufacturer]  Micron Technology, Inc.
[Package]  | FBGA package
|   typ   min   max
R_pkg   149m   129m   169m
L_pkg   2.31nH   1.51nH   3.11nH
C_pkg   0.23pF   0.11pF   0.36pF
[Pin]   signal_name   model_name   R_pin   L_pin   C_pin
A1   VSSQ   GND   158m   2.87nH   0.33pF
A2   NF   NC
A3   VSS   GND   139m   1.98nH   0.32pF
A7   VDD   POWER   140m   2.01nH   0.31pF
A8   NF   NC
A9   VDDQ   POWER   164m   3.02nH   0.33pF
B1   NC   NC
B2   VDDQ   POWER   145m   2.28nH   0.29pF
B3   DQ3   DQ_FULL   135m   1.82nH   0.13pF
B7   DQ0   DQ_FULL   140m   1.95nH   0.13pF
B8   VSSQ   GND   140m   1.95nH   0.13pF
B9   NC   NC
C1   NC   NC
C2   VSSQ   GND   142m   2.15nH   0.28pF
C3   NF   NC
C7   NF   NC
C8   VDDQ   POWER   145m   2.23nH   0.28pF
C9   NC   NC
D1   NC   NC
D2   VDDQ   POWER   140m   2.05nH   0.28pF
D3   DQ2   DQ_FULL   130m   1.56nH   0.11pF
D7   DQ3   DQ_FULL   131m   1.59nH   0.15pF
D8   VSSQ   GND
D9   NC   NC
E1   NC   NC
E2   VSSQ   GND   145m   2.12nH   0.28pF
E3   DQS   DQ_FULL   129m   1.52nH   0.12pF
E7   NC   NC
E8   VDDQ   POWER   145m   2.15nH   0.28pF
E9   NC   NC
F1   VREF   POWER   150m   2.54nH   0.26pF
F2   VSS   GND   72.9m   1.08nH   0.17pF
F3   DM   DM_INPUT   131m   1.59nH   0.28pF
F7   NC   NC
F8   VDD   POWER   72.9m   1.07nH   0.12pF
F9   NC   NC
G2   CLK   CLK_INPUT   145m   2.14nH   0.28pF
G3   CLK_   CLK_INPUT   129m   1.51nH   0.27pF
G7   WE_   INPUT   129m   1.51nH   0.28pF
G8   CAS_   INPUT   145m   2.14nH   0.27pF
H2   A12   INPUT   151m   2.31nH   0.27pF
H3   CKE   INPUT   133m   1.70nH   0.28pF
H7   RAS_   INPUT   133m   1.70nH   0.28pF
H8   CS_   INPUT   153m   2.36nH   0.28pF
J2   A11   INPUT   147m   2.29nH   0.27pF
J3   A9   INPUT   136m   1.80nH   0.27pF
J7   BA1   INPUT   137m   1.85nH   0.28pF
J8   BA0   INPUT   148m   2.32nH   0.28pF
K2   A8   INPUT   153m   2.52nH   0.31pF
K3   A7   INPUT   143m   2.12nH   0.30pF
K7   A0   INPUT   144m   2.16nH   0.30pF
K8   A10   INPUT   154m   2.59nH   0.29pF
L2   A6   INPUT   156m   2.78nH   0.31pF
L3   A5   INPUT   149m   2.40nH   0.33pF
L7   A2   INPUT   150m   2.44nH   0.33pF
L8   A1   INPUT   158m   2.84nH   0.33pF
M2   A4   INPUT   163m   3.09nH   0.35pF
M3   VSS   GND   155m   2.68nH   0.39pF
M7   VDD   POWER   155m   2.73nH   0.37pF
M8   A3   INPUT   164m   3.10nH   0.36pF
|**********************DIFF PIN*********************************************
[Diff_pin]   inv_pin   vdiff   tdelay_typ   tdelay_min   tdelay_max
   G2   G3   .360V   0ns   NA   NA
|   COMPONENT: MT46V64M8FN   10mm x 12.5mm FBGA
[Component]   MT46V64M8FN
[Manufacturer]  Micron Technology, Inc.
[Package]  | FBGA package
|   typ   min   max
R_pkg   149m   129m   169m
L_pkg   2.31nH   1.51nH   3.11nH
C_pkg   0.23pF   0.11pF   0.36pF
[Pin]   signal_name   model_name   R_pin   L_pin   C_pin
A1   VSSQ   GND   158m   2.87nH   0.33pF
A2   DQ7   DQ_FULL   147m   2.38nH   0.32pF
A3   VSS   GND   139m   1.98nH   0.32pF
A7   VDD   POWER   140m   2.01nH   0.31pF
A8   DQ0   DQ_FULL   153m   2.48nH   0.32pF
A9   VDDQ   POWER   164m   3.02nH   0.33pF
B1   NC   NC
B2   VDDQ   POWER   145m   2.28nH   0.29pF
B3   DQ6   DQ_FULL   135m   1.82nH   0.13pF
B7   DQ1   DQ_FULL   140m   1.95nH   0.13pF
B8   VSSQ   GND   140m   1.95nH   0.13pF
B9   NC   NC
C1   NC   NC
C2   VSSQ   GND   142m   2.15nH   0.28pF
C3   DQ5   DQ_FULL   132m   1.67nH   0.12pF
C7   DQ2   DQ_FULL   135m   1.75nH   0.12pF
C8   VDDQ   POWER   145m   2.23nH   0.28pF
C9   NC   NC
D1   NC   NC
D2   VDDQ   POWER   140m   2.05nH   0.28pF
D3   DQ4   DQ_FULL   130m   1.56nH   0.11pF
D7   DQ3   DQ_FULL   131m   1.59nH   0.12pF
D8   VSSQ   GND
D9   NC   NC
E1   NC   NC
E2   VSSQ   GND   145m   2.12nH   0.28pF
E3   DQS   DQ_FULL   129m   1.52nH   0.12pF
E7   NC   NC
E8   VDDQ   POWER   145m   2.15nH   0.28pF
E9   NC   NC
F1   VREF   POWER   150m   2.54nH   0.26pF
F2   VSS   GND   72.9m   1.08nH   0.17pF
F3   DM   DM_INPUT   131m   1.59nH   0.27pF
F7   NC   NC
F8   VDD   POWER   72.9m   1.07nH   0.12pF
F9   NC   NC
G2   CLK   CLK_INPUT   145m   2.14nH   0.28pF
G3   CLK_   CLK_INPUT   129m   1.51nH   0.27pF
G7   WE_   INPUT   129m   1.51nH   0.28pF
G8   CAS_   INPUT   145m   2.14nH   0.27pF
H2   A12   INPUT   151m   2.31nH   0.27pF
H3   CKE   INPUT   133m   1.70nH   0.28pF
H7   RAS_   INPUT   133m   1.70nH   0.28pF
H8   CS_   INPUT   153m   2.36nH   0.28pF
J2   A11   INPUT   147m   2.29nH   0.27pF
J3   A9   INPUT   136m   1.80nH   0.27pF
J7   BA1   INPUT   137m   1.85nH   0.28pF
J8   BA0   INPUT   148m   2.32nH   0.28pF
K2   A8   INPUT   153m   2.52nH   0.31pF
K3   A7   INPUT   143m   2.12nH   0.30pF
K7   A0   INPUT   144m   2.16nH   0.30pF
K8   A10   INPUT   154m   2.59nH   0.29pF
L2   A6   INPUT   156m   2.78nH   0.31pF
L3   A5   INPUT   149m   2.40nH   0.33pF
L7   A2   INPUT   150m   2.44nH   0.33pF
L8   A1   INPUT   158m   2.84nH   0.33pF
M2   A4   INPUT   163m   3.09nH   0.35pF
M3   VSS   GND   155m   2.68nH   0.39pF
M7   VDD   POWER   155m   2.73nH   0.37pF
M8   A3   INPUT   164m   3.10nH   0.36pF
|**********************DIFF PIN*********************************************
[Diff_pin]   inv_pin   vdiff   tdelay_typ   tdelay_min   tdelay_max
   G2   G3   .360V   0ns   NA   NA
|   COMPONENT: MT46V32M16FN   10mm x 12.5mm FBGA
[Component]   MT46V32M16FN
[Manufacturer]  Micron Technology, Inc.
[Package]  | FBGA package
|   typ   min   max
R_pkg   149m   129m   169m
L_pkg   2.31nH   1.51nH   3.11nH
C_pkg   0.23pF   0.11pF   0.36pF
[Pin]   signal_name   model_name   R_pin   L_pin   C_pin
A1   VSSQ   GND   158m   2.87nH   0.33pF
A2   DQ15   DQ   147m   2.38nH   0.32pF
A3   VSS   GND   139m   1.98nH   0.32pF
A7   VDD   POWER   140m   2.01nH   0.31pF
A8   DQ0   DQ   153m   2.48nH   0.32pF
A9   VDDQ   POWER   164m   3.02nH   0.33pF
B1   DQ14   DQ   164m   2.96nH   0.31pF
B2   VDDQ   POWER   145m   2.28nH   0.29pF
B3   DQ13   DQ   135m   1.82nH   0.13pF
B7   DQ2   DQ   140m   1.95nH   0.13pF
B8   VSSQ   GND   140m   1.95nH   0.13pF
B9   DQ1   DQ   169m   3.11nH   0.31pF
C1   DQ12   DQ   160m   2.85nH   0.29pF
C2   VSSQ   GND   142m   2.15nH   0.28pF
C3   DQ11   DQ   132m   1.67nH   0.12pF
C7   DQ4   DQ   135m   1.75nH   0.12pF
C8   VDDQ   POWER   145m   2.23nH   0.28pF
C9   DQ3   DQ   164m   2.94nH   0.29pF
D1   DQ10   DQ   156m   2.69nH   0.28pF
D2   VDDQ   POWER   140m   2.05nH   0.28pF
D3   DQ9   DQ   130m   1.56nH   0.12pF
D7   DQ6   DQ   131m   1.59nH   0.12pF
D8   VSSQ   GND
D9   DQ5   DQ   161m   2.79nH   0.28pF
E1   DQ8   DQ   154m   2.60nH   0.27pF
E2   VSSQ   GND   145m   2.12nH   0.28pF
E3   UDQS   DQ   129m   1.52nH   0.12pF
E7   LDQS   DQ   130m   1.55nH   0.26pF
E8   VDDQ   POWER   145m   2.15nH   0.28pF
E9   DQ7   DQ   157m   2.67nH   0.28pF
F1   VREF   POWER   150m   2.54nH   0.26pF
F2   VSS   GND   72.9m   1.08nH   0.17pF
F3   UDM   DM_INPUT   131m   1.59nH   0.27pF
F7   LDM   DM_INPUT   130m   1.59nH   0.26pF
F8   VDD   POWER   72.9m   1.07nH   0.12pF
F9   NC   NC
G2   CLK   CLK_INPUT   145m   2.14nH   0.28pF
G3   CLK_   CLK_INPUT   129m   1.51nH   0.27pF
G7   WE_   INPUT   129m   1.51nH   0.28pF
G8   CAS_   INPUT   145m   2.14nH   0.27pF
H2   A12   INPUT   151m   2.31nH   0.27pF
H3   CKE   INPUT   133m   1.70nH   0.28pF
H7   RAS_   INPUT   133m   1.70nH   0.28pF
H8   CS_   INPUT   153m   2.36nH   0.28pF
J2   A11   INPUT   147m   2.29nH   0.28pF
J3   A9   INPUT   136m   1.80nH   0.27pF
J7   BA1   INPUT   137m   1.85nH   0.28pF
J8   BA0   INPUT   148m   2.32nH   0.28pF
K2   A8   INPUT   153m   2.52nH   0.31pF
K3   A7   INPUT   143m   2.12nH   0.30pF
K7   A0   INPUT   144m   2.16nH   0.30pF
K8   A10   INPUT   154m   2.59nH   0.29pF
L2   A6   INPUT   156m   2.78nH   0.31pF
L3   A5   INPUT   149m   2.40nH   0.33pF
L7   A2   INPUT   150m   2.44nH   0.33pF
L8   A1   INPUT   158m   2.84nH   0.33pF
M2   A4   INPUT   163m   3.09nH   0.35pF
M3   VSS   GND   155m   2.68nH   0.39pF
M7   VDD   POWER   155m   2.73nH   0.37pF
M8   A3   INPUT   164m   3.10nH   0.36pF
|**********************DIFF PIN*********************************************
[Diff_pin]   inv_pin   vdiff   tdelay_typ   tdelay_min   tdelay_max
   G2   G3   .360V   0ns   NA   NA
| Models and submodels in the file (5): DQ_FULL (I/O), DQ_HALF (I/O), INPUT (Input), CLK_INPUT (Input), DM_INPUT (Input)
